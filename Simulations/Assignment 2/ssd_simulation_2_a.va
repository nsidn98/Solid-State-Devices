`include "disciplines.vams"
`include "constants.vams"

module pn_diode (a, c);
  inout a, c;
  electrical a, c;

  parameter real Vt   =   0.0259; // at T=300K
  parameter real Eg = 1.12;  //band gap of the material
  parameter real Nc = 2.9e+19;
  parameter real Nv = 1e+19;
  parameter real un = 1500;  //mobility
  parameter real up = 500;
  parameter real er = 11.9;  //relative permeability
  parameter real tp = 1e-6;  //diffusion time constant for hole
  parameter real tn = 1e-6;  //diffusion time constant for electron
  parameter real A  = 1e-8;  //area of the pn_diode
  parameter real T  = 300;  // temperature
  parameter real eps = 8.85e-14; //permittivity constant
  parameter real q  = 1.6e-19;  //charge
  parameter real k  = 1.38e-23;  //boltzmann constant
  parameter real Na = 1e+18;  //doping on p-side
  parameter real Nd = 1e+16;  //doping on n-side

analog begin
    real ni,p_no,n_po,Dn,Dp,Ln,Lp,Io,I_diode;
    ni=pow(Nc*Nv,0.5)*pow((T/300),1.5)*exp(Eg/(2*k*T)); // variation of ni with temp
    p_no=ni*ni/Nd;  // calculate minority carriers
    n_po=ni*ni/Na;
    Dn=un*Vt;  //calculate diffusivity
    Dp=up*Vt;
    Ln=pow(Dn*tn,0.5); //calculate diffusion length
    Lp=pow(Dp*tp,0.5);
    Io=q*A*((Dp*p_no/Lp)+(Dn*n_po/Ln));// reverse saturation current
    I_diode=Io*(exp(V(a,c)/Vt)-1);  //diode current
    I(a,c)<+I_diode; //load diode to the circuit

  end
  endmodule
